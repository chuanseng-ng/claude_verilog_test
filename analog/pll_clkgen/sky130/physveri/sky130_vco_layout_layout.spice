* NGSPICE file created from sky130_vco_layout.ext - technology: sky130A

* Top level circuit sky130_vco_layout

.end
