* NGSPICE file created from sky130_bias_layout.ext - technology: sky130A

* Top level circuit sky130_bias_layout

.end
