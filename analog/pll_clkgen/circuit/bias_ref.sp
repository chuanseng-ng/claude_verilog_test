* ============================================================
* BIAS / REFERENCE — Delta-Vt sub-1V BGR + PTAT current mirrors
* PDK:  ASAP7 predictive (PREDICTIVE_PLACEHOLDER)
* VDD:  0.7 V
* Spec:
*   Vref:           ~0.30 V (PTAT/CTAT combined)
*   TC:             <= 30 ppm/C
*   PSRR:           >= 50 dB at 10 MHz
*   Startup time:   <= 5 us
*   Power:          <= 0.1 mW
*   Area:           <= 400 um2
*   Outputs:        vbias_p (PMOS mirror gate), vbias_n (NMOS mirror gate)
*                   vref (voltage reference, optional)
*
* TOPOLOGY: Delta-Vt BGR (Razavi, sub-1V technique)
*   At 0.7 V supply, conventional BJT/diode BGR (Vref ~ 1.2 V) is infeasible.
*   Delta-Vt approach: exploit difference in threshold voltages between
*   different-geometry FinFETs (wide-fin vs narrow-fin Vth shifts), or
*   use PTAT current from (kT/q)*ln(N) / R scheme at reduced voltage.
*
*   IMPLEMENTATION (pragmatic for predictive PDK):
*   Since delta-Vt technique requires process-specific implant data
*   not available in predictive models, we implement a simplified
*   self-biased PTAT current reference using two PMOS devices with
*   different W/L and a degeneration resistor:
*
*   Topology: Wilson/Widlar current mirror variant
*   MP1 (W1/L): diode-connected, gate=drain -> sets Vgs1
*   MP2 (W2/L, W2 > W1): same Vgs2 = Vgs1 (gate shared)
*   With emitter degeneration resistor R in MP2 source:
*     Vgs1 = Vgs2 + Id2 * R  (for balance: Id2 = Id_ref)
*     delta-Vgs = Id2 * R = Vt*ln(W2/W1) (weak-inversion approx)
*     Id2 = Vt*ln(K) / R  [PTAT: proportional to T]
*
*   This gives a PTAT current Iref = Vt*ln(K)/R.
*   At T=300K: Vt=26mV, K=8 (ratio), ln(8)=2.08
*   Iref = 26mV * 2.08 / R_degen
*   For Iref = 5 uA (small for low power): R_degen = 54.1 / 5e-6 = 10.8 kOhm
*   Power = Iref * VDD = 5 uA * 0.7 V * 2 (both branches) = 7 uW [well within 100 uW]
*
* PSRR improvement:
*   Add PMOS cascode in the regulation amp output stage
*   Bypass capacitor on vbias outputs (50 fF -> -6 dB PSRR improvement at 10 MHz)
*
* Startup circuit:
*   Without startup, the PTAT mirror can be stuck in zero-current state.
*   Startup: diode-connected NMOS from vdd to ref node that is cut off
*   once the reference starts (injected current kills the degenerate state).
*
* Outputs:
*   vbias_p: PMOS gate voltage (same as MP1 gate = Vgs1 below VDD)
*            Target: VDD - Vgs_p ~ 0.7V - 0.4V = 0.3V above GND (i.e., vbias_p ~ 0.4V)
*   vbias_n: NMOS gate voltage for NMOS current mirrors
*            Generated by additional NMOS diode mirror
*            Target: Vgs_n ~ 0.35V (below VDD)
*
* SIZING:
*   MP_ref1 (W1): 4 fins, L=21nm (small, diode-connected)
*   MP_ref2 (W2): 32 fins, L=21nm (K=8 ratio)
*   R_degen: 10.8 kOhm (poly resistor)
*   Mirror copies for vbias_p: 16 fins (drives CP PMOS and VCO)
*   MN_bias (generates vbias_n): 12 fins, L=21nm
*   Filter caps: 50fF each on vbias_p, vbias_n (MOS caps)
*
* ERC notes:
*   All bulk: NMOS -> gnd, PMOS -> vdd
*   Startup device bulk -> gnd
*   No floating nodes: R_degen connects to known bias node
*   Vref node driven by MP_ref2 drain
* ============================================================

.subckt bias_ref  vbias_p  vbias_n  vref  vdd  gnd
*
* === Core PTAT reference (Widlar self-biased variant) ===
*
* MP_ref1: diode-connected PMOS (small, W=28n=4fins, L=21nm)
*   Sets reference Vgs; gate = drain = vbias_p_int
MP_ref1  vbias_p_int  vbias_p_int  vdd  vdd  pfinfet_rvt  w=28n  l=21n  nfins=4
*
* MP_ref2: larger PMOS (W=224n=32fins, L=21nm) with source degeneration
*   Source degeneration resistor R_deg in series between source and vdd
*   When MP_ref2 gate = vbias_p_int (same as MP_ref1), MP_ref2 has
*   higher W -> would have higher Id than MP_ref1 for same Vgs,
*   but R_deg drops voltage: Vgs2_eff = Vgs - Id2*R_deg -> self-regulating PTAT
R_deg  vdd  vsrc2  10800
MP_ref2  vref  vbias_p_int  vsrc2  vdd  pfinfet_rvt  w=224n  l=21n  nfins=32
*
* PTAT current now flows in both MP_ref1 and MP_ref2 branches.
* vref is the voltage at drain of MP_ref2 = Vgs_n when NMOS diode is connected.
*
* === NMOS diode to set vbias_n (NMOS mirror reference) ===
* MN_diode: diode-connected NMOS, drain tied to vref, gate=drain=vbias_n_int
MN_diode  vref  vref  gnd  gnd  nfinfet_rvt  w=84n  l=21n  nfins=12
*
* Wire vref to vbias_n through small resistor (low-impedance bias distribution)
Rbias_n  vref  vbias_n  100
*
* === Mirror output for vbias_p (drives CP and VCO PMOS references) ===
* Additional diode-connected PMOS to buffer/distribute vbias_p
MP_out   vbias_p_int  vbias_p_int  vdd  vdd  pfinfet_rvt  w=112n  l=21n  nfins=16
Rbias_p  vbias_p_int  vbias_p  100
*
* === PSRR filter capacitors on bias output nodes ===
* 50 fF MOM cap approximated as small MOS caps
* (In real implementation: MOM interdigitated caps; here: NMOS gate caps)
MC_biasp  vbias_p  gnd  gnd  gnd  nfinfet_rvt  w=28n  l=14n  nfins=4
MC_biasn  vbias_n  gnd  gnd  gnd  nfinfet_rvt  w=28n  l=14n  nfins=4
*
* === Startup circuit ===
* Problem: if all currents = 0, PTAT mirror stays dead.
* Fix: Startup device MN_strt injects a kick current from vdd to vbias_p_int
*   when vbias_p_int is near vdd (circuit is not started).
*   Once started, vbias_p_int drops below vdd - Vtp, MN_strt's Vgs < Vth -> off.
*
* MN_strt: NMOS, gate=vdd (always on in startup), drain=vbias_p_int, source=gnd
*   When vbias_p_int ~ vdd (unstarted): Vgs_MN_strt = vdd - vbias_p_int ~ 0 -> small
*   This won't inject; instead use PMOS startup:
*
* MP_strt: PMOS, gate = vbias_n (proxy for "circuit started"), drain = vbias_p_int
*   When circuit is not started: vbias_n ~ 0 -> MP_strt Vgs = 0 - vdd < Vtp -> ON
*   Injects current into vbias_p_int node -> forces MP_ref1 to conduct -> circuit starts.
*   When circuit is started: vbias_n rises to ~0.35 V -> MP_strt Vgs = 0.35-0.7=-0.35V
*   Since |Vtp| = 0.284 V: |Vgs| = 0.35 > Vtp -> MP_strt barely in weak inversion
*   -> provides a tiny trickle (acceptable) or add NMOS diode in series to kill it.
*
MP_strt  vbias_p_int  vbias_n  vdd  vdd  pfinfet_rvt  w=7n  l=7n  nfins=1
*
* === Voltage reference output ===
* vref is the drain of MP_ref2 = ~ Vgs_n_diode above gnd
* Typical value: MN_diode Vgs ~ 0.30-0.35V at 5 uA -> vref ~ 0.30-0.35V
* (No buffering here; if buffering needed, add source-follower in pll_top)
*
.ends bias_ref
* ============================================================
* End Bias_Ref subcircuit
* ============================================================
